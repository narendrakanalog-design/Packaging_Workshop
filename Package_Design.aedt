# Ansys Electronics Desktop project, version 2025.2
project datasets:
  $Au_Typical_20: (-273.15, 0.74045802) (-196.15, 0.74045802) (99.85, 1) (726.85, 1)
  $Si_Typical_5: (-273.15, 0.23376623) (-196.15, 0.23376623) (99.85, 1) (726.85, 1)
materials:
  Al-Extruded
  air: permittivity=1.0006 permeability=1.0000004
  Copper_alloy
  Mold_material
  Air-solid
  Au-Typical
  Si-Typical
  Die_attach_material
  vacuum: permittivity=1
  copper: permeability=0.999991 conductivity=58000000
  silicon: permittivity=11.9
  FR4_epoxy: permittivity=4.4 dielectric_loss_tangent=0.02
  modified_epoxy: permittivity=4.2 dielectric_loss_tangent=0.02
  epoxy_Kevlar_xy: permittivity=3.6
surface materials:
  Steel-oxidised-surface

design HFSSDesign1 (HFSS, HFSS Terminal Network, model units mm)
geometry:
  Die [silicon] = rectangle(corner=(0mm, 0mm, 0.5mm), x_size=3mm, y_size=3mm)
  Die.thicken(0.2mm)
  Substrate [FR4_epoxy] = rectangle(corner=(-1mm, -1mm, -0.1mm), x_size=5mm, y_size=5mm)
  Substrate.thicken(0.5mm)
  DieAttach [modified_epoxy] = rectangle(corner=(0mm, 0mm, 0.5mm), x_size=3mm, y_size=3mm)
  DieAttach.thicken(-0.1mm)
  diebondpad [copper] = rectangle(corner=(0.2mm, 0.2mm, 0.7mm), x_size=0.2mm, y_size=0.2mm)
  diebondpad.thicken(0.005mm)
  substratebondpad [copper] = rectangle(corner=(0.2mm, -0.7mm, 0.4mm), x_size=0.2mm, y_size=0.2mm)
  substratebondpad.thicken(0.005mm)
  Bondwire1 [vacuum] = bondwire(WireType=JEDEC_5Points WireDiameter=0.025mm NumSides=6 XPadPos=0.3mm YPadPos=0.2mm ZPadPos=0.705mm XDir=0mm YDir=-0.7mm ZDir=0mm Distance=0.7mm h1=0.2mm h2=0.3mm alpha=80deg beta=5deg WhichAxis=Z)
  Moldcompound [epoxy_Kevlar_xy] = rectangle(corner=(-1mm, -1mm, -0.1mm), x_size=5mm, y_size=5mm)
  Moldcompound.thicken(1.2mm)
